# Ansys Electronics Desktop project, version 2023.2
materials:
  vacuum: permittivity=1
  pec: conductivity=1e+30
  water_sea: permittivity=81 permeability=0.999991 conductivity=4
  silver: permeability=0.99998 conductivity=61000000
  water_fresh: permittivity=81 permeability=0.999991 conductivity=0.01
  glass: permittivity=5.5

design HFSSDesign1 (HFSS, SBR+, model units mm)
variables:
  ny = 1
  dy = ny * 0.1
geometry:
  Tx = component(Beam1, Type="Parametric Beam" Unit=mm Size=0.1mm Sheet=6 MatchedPortImpedance=50ohm Polarization=Vertical Representation="Far Field" Vertical_BeamWidth=30deg Horizontal_BeamWidth=60deg)
  coordinate_system AntennaCS = origin=(0mm, dy, 0mm) x=(1mm, 0mm, 0mm) y=(0mm, 1mm, 0mm)
  Beam1_Footprint [non-model] = part_of(Tx) in AntennaCS
  Rx = component(Beam2, Type="Parametric Beam" Unit=mm Size=0.1mm Sheet=6 MatchedPortImpedance=50ohm Polarization=Vertical Representation="Far Field" Vertical_BeamWidth=30deg Horizontal_BeamWidth=60deg)
  Beam2_Footprint [non-model] = part_of(Rx) in AntennaCS
  Sphere1 [pec] = sphere(centre=(500mm, 0mm, 0mm), radius=30mm)
boundaries and excitations:
  PerfE1: Perfect E Objects=Sphere1
  Tx_p1: Proxy Port Objects=Beam1_Footprint DefinitionPortType=-3 NumModes=1 RenormalizeAllTerminals=false Modes{Mode1{CharImp=Zpi}}
  Rx_p1: Proxy Port Objects=Beam2_Footprint DefinitionPortType=-3 NumModes=1 RenormalizeAllTerminals=false Modes{Mode1{CharImp=Zpi}}
setups:
  Setup1: HfssDriven RayDensityPerWavelength=4 MaxNumberOfBounces=5 PTDUTDSimulationSettings=None
    sweep Sweep: 1GHz to 6GHz step 0.01GHz;
source amplitudes:
  Tx_p1:1: 1W 0deg
  Rx_p1:1: 0W 0deg
reports:
  S Parameter Plot 2: mag(S(Rx_p1,Tx_p1)), ang_rad(S(Rx_p1,Tx_p1)) vs Freq on Setup1 : Sweep
  S Parameter Plot 3: dB(S(Rx_p1,Tx_p1)) vs Freq on Setup1 : Sweep [ny=all]
